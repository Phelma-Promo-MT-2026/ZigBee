// VerilogA for PLL, FDIV, veriloga

`include "constants.vams"
`include "disciplines.vams"

module FDIV(Vvco, Vdiv);
	inout Vvco, Vdiv;
	electrical Vvco, Vdiv, Vvco_1;
	parameter integer N=256;
	integer count = 0;
	parameter real vth = 0.6, vout = 1.2;

	analog begin

		if(V(Vvco) > vth && V(Vvco_1) < vth) begin
			count = count + 1;
			if(count >= N/2) begin
				count = 0;
				V(Vdiv) <= -1 * V(Vdiv);
			end
			V(Vvco_1) <= V(Vvco);
		end
		else begin
			count = count;
			V(Vvco_1) <= V(Vvco_1);
		end
	end

endmodule
