`include "constants.vams"
`include "disciplines.vams"

module FDIV(vin, vss, vout);
	input vin;
	inout vss;
	output vout;
	electrical vin, vss, vout;

	parameter real amplitude = 1.2;
	real freq = 0;

	analog begin
		@(initial_step) begin
			freq = freq + 1;
		end
		V(vout, vss) <+ freq;
	end
endmodule
