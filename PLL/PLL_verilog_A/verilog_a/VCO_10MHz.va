`include "constants.vams"
`include "disciplines.vams"

module VCO(Vctrl, vss, VoutDiv, VoutVCOp, VoutVCOm);
	//déclaration de variables
	input Vctrl;
	inout vss;
	output VoutDiv, VoutVCOp, VoutVCOm;
	electrical Vctrl, vss, VoutDiv, VoutVCOp, VoutVCOm;
	parameter real KoVCO = 524E6, KoDiv = 2E6, foVCO = 2.4E9, WoVCO = 2*`M_PI*foVCO, foDiv = 9375000, WoDiv = 2*`M_PI*foDiv;
	real W_VCODiv, phiDiv, W_VCO, phiVCO;

	analog begin
		if(V(Vctrl, vss) > 1.2) begin
			W_VCODiv = WoDiv + KoDiv*1.2;
			W_VCO = WoVCO + KoVCO*1.2;
		end
		else if(V(Vctrl, vss) <= 0) begin
			W_VCODiv = WoDiv;
			W_VCO = WoVCO;
		end
		else begin
			W_VCODiv = WoDiv + (KoDiv*V(Vctrl, vss));
			W_VCO = WoVCO + (KoVCO*V(Vctrl, vss));
		end
		phiDiv = idt(W_VCODiv, 0.0);
		phiVCO = idt(W_VCO, 0.0);
		V(VoutDiv, vss) <+ 0.6 + 0.6*cos(phiDiv);
		V(VoutVCOp, vss) <+ 0.8 + 2*cos(phiVCO);
		V(VoutVCOm, vss) <+ 0.8 - 2*cos(phiVCO);
	end
endmodule
