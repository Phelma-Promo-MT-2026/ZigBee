// VerilogA for PLL, PFD, veriloga

`include "constants.vams"
`include "disciplines.vams"

module discriminateur_frequence(in, out);
    input in;
    output out;
    electrical in, out;

    // Paramètres du discriminateur
    parameter real Fcentre = 1e6;     // Fréquence centrale [Hz]
    parameter real Kd = 1e-3;         // Gain du discriminateur [V/Hz]
    parameter real tau = 1e-6;        // Constante de temps [s]

    // Variables internes
    real freq_inst;                   // Fréquence instantanée
    real phase;                       // Phase du signal d'entrée
    real prev_phase;                  // Phase précédente
    real delta_phase;                 // Variation de phase
    real delta_time;                  // Pas de temps
    real output_voltage;
    real last_abstime = 0.0;

    analog begin
        // Initialisation
        @(initial_step) begin
            prev_phase = 0;
            output_voltage = 0;
        end

        // Calcul de la phase instantanée
        phase = atan2(V(in), ddt(V(in)));

        // Calcul de la variation de phase
        delta_phase = phase - prev_phase;
        delta_time = $abstime - last_abstime;

        // Calcul de la fréquence instantanée
        if (delta_time > 0) begin
            freq_inst = delta_phase / (2 * `M_PI * delta_time);

            // Calcul de la tension de sortie (proportionnelle à l'écart de fréquence)
            output_voltage = Kd * (freq_inst - Fcentre);
        end
        last_abstime = $abstime;

        // Mise à jour de la phase précédente
        prev_phase = phase;

        // Application d'un filtre passe-bas pour lisser la sortie
        V(out) <+ output_voltage;
    end
endmodule
