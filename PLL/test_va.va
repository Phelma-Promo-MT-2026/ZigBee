// VerilogA for PLL, PFD, veriloga

`include "constants.vams"
`include "disciplines.vams"

module va_resistor(p,n) ;
	inout p,n;
	parameter real resistance = 1000.0 from (0.0:inf] ;
	electrical p, n ;

	analog
	I(p,n) <+ V(p,n)/resistance ;
endmodule
