`include "constants.vams"
`include "disciplines.vams"

module TEST(in, out, vss);
	input in;
	inout vss;
	output out;
	electrical in, out, vss;
	integer state, next_state;

	analog begin
		@(initial_step) begin
			state = 0;
			next_state = 1;
		end
		if(V(in) == 0)begin

			state = next_state;
		end else begin
			next_state = state + 1;
		end
		V(out, vss) <+ (state == 1 ? V(in) : -V(in));
	end
endmodule45
