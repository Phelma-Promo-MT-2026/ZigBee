// VerilogA for PLL, VCO, veriloga

`include "constants.vams"
`include "disciplines.vams"

module VCO(Vctrl, vss, Vout);
	//déclaration de variables
	input Vctrl;
	inout vss;
	output Vout;
	electrical Vctrl, vss, Vout;
	parameter real Ko = 200E6, fo = 2.45E9, Wo = 2*3.14*fo;
	real W_VCO, phi;

	analog begin
		if(V(Vctrl, vss) > 1.2) begin
			W_VCO = Wo + Ko*1.2;
		end
		else if(V(Vctrl, vss) < 0) begin
			W_VCO = Wo;
		end
		else begin
			W_VCO = Wo + (Ko*V(Vctrl, vss));
		end
		//phi = W_VCO * $abstime;
		phi = idt(W_VCO, 0.0);
		V(Vout, vss) <+ 0.6 + 0.6*cos(phi);
		//V(Vout, vss) <+ sin(2*`M_PI*V(Vctrl, vss)*W_VCO);
	end
endmodule
