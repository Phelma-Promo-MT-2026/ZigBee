// VerilogA for PLL, VCO, veriloga

`include "constants.vams"
`include "disciplines.vams"

module VCO(Vctrl, Vout);
	//dclaration de variables
	inout Vctrl, Vout;
	electrical Vctrl, Vout;
	parameter real Ko = 90E3, fo = 10E6, Wo = 2*3.14*fo;
	real W_VCO, phi;

	analog begin
		if(V(Vctrl) > 1.2) begin
			W_VCO = Wo + Ko*1.2;
		end
		else if(V(Vctrl) < 0)begin
			W_VCO = Wo;
		end
		else begin
			W_VCO = Wo + (Ko*V(Vctrl));
		end
		phi = idt(W_VCO, 0);
		V(Vout) <+ 0.6 + 0.6*cos(phi);
	end
endmodule
